* Skywater PDK DFF Setup Time (1 -> 0 Transition) - 2D Slew Sweep (10ps, 1000ps)
.lib /foss/pdks/sky130A/libs.tech/ngspice/sky130.lib.spice tt

* --- Subcircuits ---
.subckt inv1x A Y VP VN
X0 Y A VP VP sky130_fd_pr__pfet_01v8 ad=0.8064u pd=6.32u as=0.756u ps=6.24u w=1.26 l=0.15
X1 Y A VN VN sky130_fd_pr__nfet_01v8 ad=0.2688u pd=2.96u as=0.252u ps=2.88u w=0.42 l=0.15
C0 VP A 0.08312f
C1 A Y 0.02881f
C2 VP Y 0.05132f
C3 Y VN 0.14836f
C4 A VN 0.32795f
C5 VP VN 0.53176f
.ends

.subckt dff1x clk d q vdd vss
X0 a_1422_n636# clk a_268_n636# vdd sky130_fd_pr__pfet_01v8 ad=0.126 pd=1.44 as=0.126 ps=1.14 w=0.42 l=0.15
X1 a_1996_n636# a_1708_n636# vdd vdd sky130_fd_pr__pfet_01v8 ad=0.378 pd=3.42 as=0.378 ps=3.11394 w=1.26 l=0.15
X2 a_n18_n636# a_n180_n330# a_n308_n636# vdd sky130_fd_pr__pfet_01v8 ad=0.126 pd=1.44 as=0.126 ps=1.14 w=0.42 l=0.15
X3 a_n308_n636# d vss vss sky130_fd_pr__nfet_01v8 ad=0.126 pd=1.44 as=0.126 ps=1.44 w=0.42 l=0.15
X4 q a_1708_n636# vss vss sky130_fd_pr__nfet_01v8 ad=0.126 pd=1.44 as=0.126 ps=1.44 w=0.42 l=0.15
X5 q a_1708_n636# vdd vdd sky130_fd_pr__pfet_01v8 ad=0.405 pd=3.3 as=0.405 ps=3.33636 w=1.35 l=0.15
X6 a_268_n636# a_n18_n636# vss vss sky130_fd_pr__nfet_01v8 ad=0.126 pd=1.44 as=0.126 ps=1.44 w=0.42 l=0.15
X7 a_1422_n636# a_n180_n330# a_268_n636# vss sky130_fd_pr__nfet_01v8 ad=0.126 pd=1.44 as=0.126 ps=1.44 w=0.42 l=0.15
X8 a_1422_n636# a_n180_n330# a_1996_n636# vdd sky130_fd_pr__pfet_01v8 ad=0.126 pd=1.44 as=0.126 ps=1.14 w=0.42 l=0.15
X9 a_556_n636# a_268_n636# vss vss sky130_fd_pr__nfet_01v8 ad=0.126 pd=1.44 as=0.126 ps=1.44 w=0.42 l=0.15
X10 a_n18_n636# clk a_n308_n636# vss sky130_fd_pr__nfet_01v8 ad=0.126 pd=1.44 as=0.126 ps=1.44 w=0.42 l=0.15
X11 a_n180_n330# clk vss vss sky130_fd_pr__nfet_01v8 ad=0.126 pd=1.44 as=0.126 ps=1.44 w=0.42 l=0.15
X12 a_n308_n636# d vdd vdd sky130_fd_pr__pfet_01v8 ad=0.378 pd=3.42 as=0.378 ps=3.11394 w=1.26 l=0.15
X13 a_268_n636# a_n18_n636# vdd vdd sky130_fd_pr__pfet_01v8 ad=0.378 pd=3.42 as=0.378 ps=3.11394 w=1.26 l=0.15
X14 a_n18_n636# clk a_556_n636# vdd sky130_fd_pr__pfet_01v8 ad=0.126 pd=1.44 as=0.126 ps=1.14 w=0.42 l=0.15
X15 a_1422_n636# clk a_1996_n636# vss sky130_fd_pr__nfet_01v8 ad=0.126 pd=1.44 as=0.126 ps=1.44 w=0.42 l=0.15
X16 a_1708_n636# a_1422_n636# vss vss sky130_fd_pr__nfet_01v8 ad=0.126 pd=1.44 as=0.126 ps=1.44 w=0.42 l=0.15
X17 a_556_n636# a_268_n636# vdd vdd sky130_fd_pr__pfet_01v8 ad=0.378 pd=3.42 as=0.378 ps=3.11394 w=1.26 l=0.15
X18 a_1996_n636# a_1708_n636# vss vss sky130_fd_pr__nfet_01v8 ad=0.126 pd=1.44 as=0.126 ps=1.44 w=0.42 l=0.15
X19 a_n180_n330# clk vdd vdd sky130_fd_pr__pfet_01v8 ad=0.378 pd=3.12 as=0.378 ps=3.11394 w=1.26 l=0.15
X20 a_n18_n636# a_n180_n330# a_556_n636# vss sky130_fd_pr__nfet_01v8 ad=0.126 pd=1.44 as=0.126 ps=1.44 w=0.42 l=0.15
X21 a_1708_n636# a_1422_n636# vdd vdd sky130_fd_pr__pfet_01v8 ad=0.378 pd=3.12 as=0.378 ps=3.11394 w=1.26 l=0.15
C0 a_1708_n636# a_n18_n636# 0
C1 d a_n180_n330# 0.00328f
C2 a_1708_n636# a_268_n636# 0.00603f
C3 a_556_n636# a_n18_n636# 0.18702f
C4 a_n18_n636# a_1422_n636# 0.0049f
C5 a_n18_n636# clk 0.23578f
C6 d a_n18_n636# 0.00191f
C7 a_556_n636# a_268_n636# 0.06668f
C8 a_1708_n636# a_1996_n636# 0.06455f
C9 a_268_n636# a_1422_n636# 0.15287f
C10 clk a_268_n636# 0.26117f
C11 a_1708_n636# a_1422_n636# 0.16736f
C12 a_1708_n636# clk 0.25935f
C13 d a_268_n636# 0
C14 a_1996_n636# a_1422_n636# 0.18801f
C15 clk a_1996_n636# 0.1324f
C16 q a_1708_n636# 0.03638f
C17 a_556_n636# a_1422_n636# 0
C18 a_556_n636# clk 0.10746f
C19 clk a_1422_n636# 0.11595f
C20 d clk 0.01557f
C21 q a_1422_n636# 0.02012f
C22 vdd a_n308_n636# 0.08414f
C23 a_n308_n636# a_n180_n330# 0.08693f
C24 vdd a_n180_n330# 0.54209f
C25 a_n18_n636# a_n308_n636# 0.1494f
C26 a_n18_n636# vdd 0.15957f
C27 a_268_n636# a_n308_n636# 0
C28 a_268_n636# vdd 0.82661f
C29 a_1708_n636# vdd 0.69044f
C30 a_n18_n636# a_n180_n330# 0.22561f
C31 a_1996_n636# vdd 0.0644f
C32 clk a_n308_n636# 0.12189f
C33 a_556_n636# vdd 0.06959f
C34 vdd a_1422_n636# 0.18609f
C35 clk vdd 0.72504f
C36 a_268_n636# a_n180_n330# 0.4284f
C37 d a_n308_n636# 0.02759f
C38 a_1708_n636# a_n180_n330# 0.11083f
C39 d vdd 0.08222f
C40 q vdd 0.02645f
C41 a_1996_n636# a_n180_n330# 0.13142f
C42 a_n18_n636# a_268_n636# 0.11957f
C43 a_556_n636# a_n180_n330# 0.16449f
C44 a_n180_n330# a_1422_n636# 0.17231f
C45 clk a_n180_n330# 0.76148f
C46 q vss 0.11048f
C47 clk vss 1.05813f
C48 d vss 0.21374f
C49 vdd vss 3.39055f
C50 a_1996_n636# vss 0.1699f
C51 a_556_n636# vss 0.16477f
C52 a_n308_n636# vss 0.22551f
C53 a_1708_n636# vss 0.56831f
C54 a_1422_n636# vss 0.89214f
C55 a_268_n636# vss 0.359f
C56 a_n18_n636# vss 0.87426f
C57 a_n180_n330# vss 0.87024f
.ends

* --- Power Supplies ---
VDD vdd 0 DC 1.8

* --- Dummy Source Declarations (Reconfigured in .control block) ---
Vclk clk 0 PULSE(1.8 0 5n 10p 10p 4.99n 10n)
* CHANGED: Data now starts HIGH (1.8) and transitions LOW (0)
Vd d 0 PULSE(1.8 0 14.5n 10p 10p 20n 40n)

* --- DUT ---
Xdff1 clk d out vdd 0 dff1x
Xnot2 out out2 vdd 0 inv1x

* --- Control Block: 2D Slew Sweep Binary Search ---
.control
  * 1. Define the slew matrix [10ps, 1000ps]
  let slews = vector(2)
  let slews[0] = 10e-12
  let slews[1] = 1000e-12

  let num_slews = 2

  echo "--- DFF SETUP TIME: 2D SLEW CHARACTERIZATION (1 -> 0) ---"

  let idx_clk = 0

  * Outer Loop: Clock Slew
  while idx_clk < num_slews
      let s_clk = slews[idx_clk]

      let idx_d = 0

      * Inner Loop: Data Slew
      while idx_d < num_slews
          let s_d = slews[idx_d]

          * 2. Configure 50% crossing geometry
          let clk_edge_start = 15.0n
          let clk_50 = clk_edge_start + (s_clk / 2.0)

          * 3. Adjust Vclk Pulse
          let pw_clk = 5.0n - s_clk
          alter @Vclk[pulse] = [ 1.8 0 5n $&s_clk $&s_clk $&pw_clk 10n ]

          * 4. Binary Search Setup
          let td_min = 13.0n
          let td_max = 16.0n
          let tol = 0.001n
          let iter = 0

          while (td_max - td_min) > tol
              let iter = iter + 1
              let td = (td_min + td_max) / 2.0

              * CHANGED: Data edge transitions 1.8 -> 0 at 'td'
              alter @Vd[pulse] = [ 1.8 0 $&td $&s_d $&s_d 20n 40n ]

              tran 1p 20n

              * Measure output voltage 4ns after clock edge
              meas tran q_voltage FIND v(out) AT=19n

              * CHANGED: If successfully latched '0', output will be LOW (< 0.9)
              if q_voltage < 0.9
                  * PASS: Flipped successfully to 0
                  let td_min = td
              else
                  * FAIL: Arrived too late (stayed 1)
                  let td_max = td
              end
          end

          * 5. Final Calculation
          let data_50 = td_min + (s_d / 2.0)
          let best_setup = clk_50 - data_50

          echo "Clk Slew: $&s_clk s  |  Data Slew: $&s_d s  |  Setup: $&best_setup s"
          plot V(out) V(d) V(clk)

          let idx_d = idx_d + 1
      end
      echo "-----------------------------------------------------------------"
      let idx_clk = idx_clk + 1
  end
  echo "Sweep Complete."
.endc

.end
