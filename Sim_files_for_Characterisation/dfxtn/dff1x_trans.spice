* Skywater PDK DFF pex trans Testbench
* Geometric Formulas:
* as = W * 2 * L
* ad = W * 2 * L
* ps = 2 * (W + 2 * L)
* pd = 2 * (W + 2 * L)
.lib /foss/pdks/sky130A/libs.tech/ngspice/sky130.lib.spice tt

.subckt inv1x a z vdd vss
xm01 z a vdd vdd sky130_fd_pr__pfet_01v8 l=0.15 w=1.261 as=0.3783 ad=0.3783 ps=3.122 pd=3.122
xm02 z a vss vss sky130_fd_pr__nfet_01v8 l=0.15 w=0.42 as=0.126 ad=0.126 ps=1.44 pd=1.44
.ends

.subckt dff1x clk d q vdd vss
X0 a_1422_n636# clk a_268_n636# vdd sky130_fd_pr__pfet_01v8 ad=0.126 pd=1.44 as=0.126 ps=1.14 w=0.42 l=0.15
X1 a_1996_n636# a_1708_n636# vdd vdd sky130_fd_pr__pfet_01v8 ad=0.378 pd=3.42 as=0.378 ps=3.11394 w=1.26 l=0.15
X2 a_n18_n636# a_n180_n330# a_n308_n636# vdd sky130_fd_pr__pfet_01v8 ad=0.126 pd=1.44 as=0.126 ps=1.14 w=0.42 l=0.15
X3 a_n308_n636# d vss vss sky130_fd_pr__nfet_01v8 ad=0.126 pd=1.44 as=0.126 ps=1.44 w=0.42 l=0.15
X4 q a_1708_n636# vss vss sky130_fd_pr__nfet_01v8 ad=0.126 pd=1.44 as=0.126 ps=1.44 w=0.42 l=0.15
X5 q a_1708_n636# vdd vdd sky130_fd_pr__pfet_01v8 ad=0.405 pd=3.3 as=0.405 ps=3.33636 w=1.35 l=0.15
X6 a_268_n636# a_n18_n636# vss vss sky130_fd_pr__nfet_01v8 ad=0.126 pd=1.44 as=0.126 ps=1.44 w=0.42 l=0.15
X7 a_1422_n636# a_n180_n330# a_268_n636# vss sky130_fd_pr__nfet_01v8 ad=0.126 pd=1.44 as=0.126 ps=1.44 w=0.42 l=0.15
X8 a_1422_n636# a_n180_n330# a_1996_n636# vdd sky130_fd_pr__pfet_01v8 ad=0.126 pd=1.44 as=0.126 ps=1.14 w=0.42 l=0.15
X9 a_556_n636# a_268_n636# vss vss sky130_fd_pr__nfet_01v8 ad=0.126 pd=1.44 as=0.126 ps=1.44 w=0.42 l=0.15
X10 a_n18_n636# clk a_n308_n636# vss sky130_fd_pr__nfet_01v8 ad=0.126 pd=1.44 as=0.126 ps=1.44 w=0.42 l=0.15
X11 a_n180_n330# clk vss vss sky130_fd_pr__nfet_01v8 ad=0.126 pd=1.44 as=0.126 ps=1.44 w=0.42 l=0.15
X12 a_n308_n636# d vdd vdd sky130_fd_pr__pfet_01v8 ad=0.378 pd=3.42 as=0.378 ps=3.11394 w=1.26 l=0.15
X13 a_268_n636# a_n18_n636# vdd vdd sky130_fd_pr__pfet_01v8 ad=0.378 pd=3.42 as=0.378 ps=3.11394 w=1.26 l=0.15
X14 a_n18_n636# clk a_556_n636# vdd sky130_fd_pr__pfet_01v8 ad=0.126 pd=1.44 as=0.126 ps=1.14 w=0.42 l=0.15
X15 a_1422_n636# clk a_1996_n636# vss sky130_fd_pr__nfet_01v8 ad=0.126 pd=1.44 as=0.126 ps=1.44 w=0.42 l=0.15
X16 a_1708_n636# a_1422_n636# vss vss sky130_fd_pr__nfet_01v8 ad=0.126 pd=1.44 as=0.126 ps=1.44 w=0.42 l=0.15
X17 a_556_n636# a_268_n636# vdd vdd sky130_fd_pr__pfet_01v8 ad=0.378 pd=3.42 as=0.378 ps=3.11394 w=1.26 l=0.15
X18 a_1996_n636# a_1708_n636# vss vss sky130_fd_pr__nfet_01v8 ad=0.126 pd=1.44 as=0.126 ps=1.44 w=0.42 l=0.15
X19 a_n180_n330# clk vdd vdd sky130_fd_pr__pfet_01v8 ad=0.378 pd=3.12 as=0.378 ps=3.11394 w=1.26 l=0.15
X20 a_n18_n636# a_n180_n330# a_556_n636# vss sky130_fd_pr__nfet_01v8 ad=0.126 pd=1.44 as=0.126 ps=1.44 w=0.42 l=0.15
X21 a_1708_n636# a_1422_n636# vdd vdd sky130_fd_pr__pfet_01v8 ad=0.378 pd=3.12 as=0.378 ps=3.11394 w=1.26 l=0.15
C0 a_1708_n636# a_n18_n636# 0
C1 d a_n180_n330# 0.00328f
C2 a_1708_n636# a_268_n636# 0.00603f
C3 a_556_n636# a_n18_n636# 0.18702f
C4 a_n18_n636# a_1422_n636# 0.0049f
C5 a_n18_n636# clk 0.23578f
C6 d a_n18_n636# 0.00191f
C7 a_556_n636# a_268_n636# 0.06668f
C8 a_1708_n636# a_1996_n636# 0.06455f
C9 a_268_n636# a_1422_n636# 0.15287f
C10 clk a_268_n636# 0.26117f
C11 a_1708_n636# a_1422_n636# 0.16736f
C12 a_1708_n636# clk 0.25935f
C13 d a_268_n636# 0
C14 a_1996_n636# a_1422_n636# 0.18801f
C15 clk a_1996_n636# 0.1324f
C16 q a_1708_n636# 0.03638f
C17 a_556_n636# a_1422_n636# 0
C18 a_556_n636# clk 0.10746f
C19 clk a_1422_n636# 0.11595f
C20 d clk 0.01557f
C21 q a_1422_n636# 0.02012f
C22 vdd a_n308_n636# 0.08414f
C23 a_n308_n636# a_n180_n330# 0.08693f
C24 vdd a_n180_n330# 0.54209f
C25 a_n18_n636# a_n308_n636# 0.1494f
C26 a_n18_n636# vdd 0.15957f
C27 a_268_n636# a_n308_n636# 0
C28 a_268_n636# vdd 0.82661f
C29 a_1708_n636# vdd 0.69044f
C30 a_n18_n636# a_n180_n330# 0.22561f
C31 a_1996_n636# vdd 0.0644f
C32 clk a_n308_n636# 0.12189f
C33 a_556_n636# vdd 0.06959f
C34 vdd a_1422_n636# 0.18609f
C35 clk vdd 0.72504f
C36 a_268_n636# a_n180_n330# 0.4284f
C37 d a_n308_n636# 0.02759f
C38 a_1708_n636# a_n180_n330# 0.11083f
C39 d vdd 0.08222f
C40 q vdd 0.02645f
C41 a_1996_n636# a_n180_n330# 0.13142f
C42 a_n18_n636# a_268_n636# 0.11957f
C43 a_556_n636# a_n180_n330# 0.16449f
C44 a_n180_n330# a_1422_n636# 0.17231f
C45 clk a_n180_n330# 0.76148f
C46 q vss 0.11048f
C47 clk vss 1.05813f
C48 d vss 0.21374f
C49 vdd vss 3.39055f
C50 a_1996_n636# vss 0.1699f
C51 a_556_n636# vss 0.16477f
C52 a_n308_n636# vss 0.22551f
C53 a_1708_n636# vss 0.56831f
C54 a_1422_n636# vss 0.89214f
C55 a_268_n636# vss 0.359f
C56 a_n18_n636# vss 0.87426f
C57 a_n180_n330# vss 0.87024f
.ends

* the voltage source:
Vclk clk 0 PULSE(0 1.8 0 1000p 1000p 5000p 10n)
VDD vdd 0 DC 1.8
Vd d 0 PULSE(0 1.8 0 10p 10p 10n 20n)
Xdff1 clk d out vdd gnd dff1x
c_load out gnd 100f

* trans analysis
.tran 1p 50n

.meas tran trise TRIG V(out) VAL=0.36 RISE=1 TARG V(out) VAL=1.44 RISE=2

.meas tran tfall TRIG V(out) VAL=1.44 FALL=1 TARG V(out) VAL=0.36 FALL=1

.meas tran cellrise TRIG v(clk) VAL=0.9 FALL=3 TARG v(out) VAL=0.9 RISE=1

.meas tran cellfall TRIG v(clk) VAL=0.9 FALL=2 TARG v(out) VAL=0.9 FALL=1

.control
run
plot V(clk) V(out) V(d)
.endc
.end
