* NGSPICE - NOR3 INPUT PIN CAPACITANCE CHARACTERIZATION
* Measures input capacitance at A, B and C

.lib /foss/pdks/sky130A/libs.tech/ngspice/sky130.lib.spice tt

.subckt NOR3 A B C Y VP VN
X0 Y A VN VN sky130_fd_pr__nfet_01v8 ad=0.0966 pd=1.02 as=0.0966 ps=1.02 w=0.42 l=0.15
X1 a_297_186# B a_7_186# VP sky130_fd_pr__pfet_01v8 ad=0.21 pd=1.59333 as=0.21 ps=1.59333 w=1.26 l=0.15
X2 a_297_186# B a_7_186# VP sky130_fd_pr__pfet_01v8 ad=0.21 pd=1.59333 as=0.21 ps=1.59333 w=1.26 l=0.15
X3 Y C VN VN sky130_fd_pr__nfet_01v8 ad=0.0966 pd=1.02 as=0.0966 ps=1.02 w=0.42 l=0.15
X4 Y C a_297_186# VP sky130_fd_pr__pfet_01v8 ad=0.2919 pd=2.14333 as=0.21 ps=1.59333 w=1.26 l=0.15
X5 Y C a_297_186# VP sky130_fd_pr__pfet_01v8 ad=0.2919 pd=2.14333 as=0.21 ps=1.59333 w=1.26 l=0.15
X6 a_7_186# B a_297_186# VP sky130_fd_pr__pfet_01v8 ad=0.21 pd=1.59333 as=0.21 ps=1.59333 w=1.26 l=0.15
X7 VN B Y VN sky130_fd_pr__nfet_01v8 ad=0.0966 pd=1.02 as=0.0966 ps=1.02 w=0.42 l=0.15
X8 VP A a_7_186# VP sky130_fd_pr__pfet_01v8 ad=0.2898 pd=2.14 as=0.21 ps=1.59333 w=1.26 l=0.15
X9 a_7_186# A VP VP sky130_fd_pr__pfet_01v8 ad=0.21 pd=1.59333 as=0.2898 ps=2.14 w=1.26 l=0.15
X10 a_7_186# A VP VP sky130_fd_pr__pfet_01v8 ad=0.21 pd=1.59333 as=0.2898 ps=2.14 w=1.26 l=0.15
X11 a_297_186# C Y VP sky130_fd_pr__pfet_01v8 ad=0.21 pd=1.59333 as=0.2919 ps=2.14333 w=1.26 l=0.15
C0 a_297_186# A 0.00218f
C1 B A 0.05527f
C2 a_7_186# A 0.03309f
C3 C A 0
C4 B a_297_186# 0.05293f
C5 a_297_186# a_7_186# 0.08691f
C6 B a_7_186# 0.02486f
C7 a_297_186# C 0.02891f
C8 B C 0.05535f
C9 A Y 0.00711f
C10 C a_7_186# 0.00161f
C11 VP A 0.22182f
C12 a_297_186# Y 0.09207f
C13 B Y 0.0345f
C14 VP a_297_186# 0.06789f
C15 a_7_186# Y 0.00675f
C16 B VP 0.12777f
C17 C Y 0.13123f
C18 VP a_7_186# 0.12084f
C19 VP C 0.16169f
C20 VP Y 0.06088f
C21 Y VN 0.46211f
C22 C VN 0.45258f
C23 B VN 0.1732f
C24 A VN 0.41564f
C25 VP VN 1.49156f
C26 a_297_186# VN 0.07086f
C27 a_7_186# VN 0.09724f
.ends

VDD vdd 0 DC 1.8

* INPUT A CAPACITANCE, B = 0, C = 0

VA A_in 0 PULSE(0 1.8 0 20p 20p 500p 1n)

* Ammeter for current entering A
Vammeter_A A_in A 0 DC 0

VB_A B_A 0 DC 0
VC_A C_A 0 DC 0

Xnor_A A B_A C_A out_A vdd 0 NOR3

* INPUT B CAPACITANCE, A = 0, C = 0

VA_B A_B 0 DC 0

VB B_in 0 PULSE(0 1.8 0 20p 20p 500p 1n)

* Ammeter for current entering B
Vammeter_B B_in B 0 DC 0

VC_B C_B 0 DC 0

Xnor_B A_B B C_B out_B vdd 0 NOR3

* INPUT C CAPACITANCE, A = 0, B = 0

VA_C A_C 0 DC 0
VB_C B_C 0 DC 0

VC C_in 0 PULSE(0 1.8 0 20p 20p 500p 1n)

* Ammeter for current entering C
Vammeter_C C_in C 0 DC 0

Xnor_C A_C B_C C out_C vdd 0 NOR3

.tran 1p 1.5n

* INPUT A CAPACITANCE

* Rising: 0 -> 1.8 V over 20 ps
.meas tran q_A_rise INTEG I(Vammeter_A) FROM=0p TO=20p
.meas tran c_A_rise_F param='q_A_rise/1.8'
.meas tran c_A_rise_pF param='c_A_rise_F * 1e12'

* Falling: 1.8 -> 0 V from 520 ps -> 540 ps
.meas tran q_A_fall_raw INTEG I(Vammeter_A) FROM=520p TO=540p
.meas tran c_A_fall_F param='-q_A_fall_raw/1.8'
.meas tran c_A_fall_pF param='c_A_fall_F * 1e12'

.meas tran c_A_avg_pF param='(c_A_rise_pF + c_A_fall_pF)/2'

* INPUT B CAPACITANCE

.meas tran q_B_rise INTEG I(Vammeter_B) FROM=0p TO=20p
.meas tran c_B_rise_F param='q_B_rise/1.8'
.meas tran c_B_rise_pF param='c_B_rise_F * 1e12'

.meas tran q_B_fall_raw INTEG I(Vammeter_B) FROM=520p TO=540p
.meas tran c_B_fall_F param='-q_B_fall_raw/1.8'
.meas tran c_B_fall_pF param='c_B_fall_F * 1e12'

.meas tran c_B_avg_pF param='(c_B_rise_pF + c_B_fall_pF)/2'

* INPUT C CAPACITANCE

.meas tran q_C_rise INTEG I(Vammeter_C) FROM=0p TO=20p
.meas tran c_C_rise_F param='q_C_rise/1.8'
.meas tran c_C_rise_pF param='c_C_rise_F * 1e12'

.meas tran q_C_fall_raw INTEG I(Vammeter_C) FROM=520p TO=540p
.meas tran c_C_fall_F param='-q_C_fall_raw/1.8'
.meas tran c_C_fall_pF param='c_C_fall_F * 1e12'

.meas tran c_C_avg_pF param='(c_C_rise_pF + c_C_fall_pF)/2'

.control

run

print c_A_rise_pF c_A_fall_pF c_A_avg_pF
print c_B_rise_pF c_B_fall_pF c_B_avg_pF
print c_C_rise_pF c_C_fall_pF c_C_avg_pF

plot V(A_in) V(out_A)
plot V(B_in) V(out_B)
plot V(C_in) V(out_C)

.endc

.end
