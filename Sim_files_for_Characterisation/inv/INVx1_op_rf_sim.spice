* NGSPICE Standard Cell Characterization - Output Transitions
.lib /foss/pdks/sky130A/libs.tech/ngspice/sky130.lib.spice tt

.subckt INVX1_Saniya_new_pex_Subckt A Y VP VN
X0 Y A VP VP sky130_fd_pr__pfet_01v8 ad=0.8064u pd=6.32u as=0.756u ps=6.24u w=1.26 l=0.15
X1 Y A VN VN sky130_fd_pr__nfet_01v8 ad=0.2688u pd=2.96u as=0.252u ps=2.88u w=0.42 l=0.15
C0 VP A 0.08312f
C1 A Y 0.02881f
C2 VP Y 0.05132f
C3 Y VN 0.14836f
C4 A VN 0.32795f
C5 VP VN 0.53176f
.ends

* Parameter definitions for sweeping
.param input_slew=10p
.param output_load=0.5f

VDD vdd 0 DC 1.8
Vin in 0 PULSE(0 1.8 0 {input_slew} {input_slew} 2.5n 5n)

Xnot1 in out vdd 0 INVX1_Saniya_new_pex_Subckt
Cload out 0 {output_load}

.control
  * 3x3 Nested loop for Slew vs. Load combinations
  foreach slew_val 10p 100p 1000p
    foreach load_val 0.5f 10f 100f

      * Update parameters and reset circuit state
      alterparam input_slew = $slew_val
      alterparam output_load = $load_val
      reset

      tran 1p 6n

      print "=== Input Slew: $slew_val | Output Load: $load_val ==="

      * 1. Measure raw time in seconds (20% to 80% thresholds)
      meas tran rise_sec TRIG V(out) VAL=0.36 RISE=1 TARG V(out) VAL=1.44 RISE=1
      meas tran fall_sec TRIG V(out) VAL=1.44 FALL=1 TARG V(out) VAL=0.36 FALL=1

      * 2. Convert raw seconds to nanoseconds (ns) using 'let'
      let rise_ns = rise_sec * 1e9
      let fall_ns = fall_sec * 1e9

      print rise_ns fall_ns

      plot V(in) V(out) title "Slew: $slew_val, Load: $load_val"

    end
  end
.endc
.end
